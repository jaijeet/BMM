// A device with hysteresis
`include "disciplines.vams"

module hys_template(p, n);
    inout p, n;
    electrical p, n, ns;
    parameter real R = 1e3 from (0:inf);
    parameter real k = 1 from (0:inf);
    parameter real tau = 1e-5 from (0:inf);
    real s;

    analog begin
        s = V(ns, n);
        I(p, n)  <+ V(p, n)/R * (1+tanh(k*s));
        I(ns, n) <+ V(p, n) - pow(s, 3) + s;
        I(ns, n) <+ ddt(-tau*s);
    end
endmodule
